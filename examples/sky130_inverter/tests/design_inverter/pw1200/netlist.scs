// inverter_tb

simulator lang=spectre

// This is a generated file.
// Be careful when editing manually: this file may be overwritten.

include "/Users/rahul/acads/research/sky130/pdk/skywater-pdk/MODELS/SPECTRE/s8phirs_10r/Models/tt.cor"

subckt nfet_01v8_1200x150x1 ( io_d io_g io_s io_b )

  rawinst0 ( io_d io_g io_s io_b ) nshort l=0.150 nf=1 w=1.200

ends nfet_01v8_1200x150x1

subckt pfet_01v8_1200x150x1 ( io_d io_g io_s io_b )

  rawinst0 ( io_d io_g io_s io_b ) pshort w=1.200 l=0.150 nf=1

ends pfet_01v8_1200x150x1

subckt inverter ( io_vdd io_vss io_din io_dout )

  xinst0 ( io_dout io_din io_vss io_vss ) nfet_01v8_1200x150x1
  xinst1 ( io_dout io_din io_vdd io_vdd ) pfet_01v8_1200x150x1

ends inverter

subckt uservsource ( io_p io_n )

V0 ( io_p io_n ) vsource type=dc dc=1.8

ends uservsource

subckt uservsource_1 ( io_p io_n )

V0 ( io_p io_n ) vsource type=pulse val0=0 val1=1.8 rise=0.000000000001 fall=0.000000000001 width=0.000000001 delay=0.0000000001

ends uservsource_1

xinst0 ( vdd 0 xinst0_din dout ) inverter
xinst1 ( vdd 0 ) uservsource
xinst2 ( xinst0_din 0 ) uservsource_1

analysis0 tran stop=0.000000002 errpreset=conservative
